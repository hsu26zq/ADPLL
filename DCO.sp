*** Voltage: 1.8V ***
.PARAM supply=1.8

**********************
* Define Global Nets *
**********************
.GLOBAL VDD VSS

**********************
* Voltage Sources    *
**********************
vdd VDD DC supply
VSS VSS DC 0

**********************
* Subckt Definition  *
**********************
SUBCKT BUFFER A iinn0 iinnl iinn2 iinn3 iinn4 iinn5 iinn6 iinn7 iinn8 iinn9 iinn10 iinnl1 iinn12 iinn13 iinn14 iinn15
+ iinn16 iinn17 iinn18 iinn19 iinn20 iinn21 iinn22 iinn23 iinn24 iinn25 iinn26 iinn27 iinn28 iinn29 iinn30 iinn31
+ iinn32 iinn33 iinn34 iinn35 iinn36 iinn37 iinn38 iinn39 iinn40 iinn41 iinn42 iinn43 iinn44 iinn45 iinn46 iinn47
+ iinn48 iinn49 iinn50 iinn51 iinn52 iinn53 iinn54 iinn55 iinn56 iinn57 iinn58 iinn59 iinn60 iinn61 iinn62 iinn63
+ iinn64 iinn65 iinn66 iinn67 iinn68 iinn69 iinn70 iinn71 iinn72 iinn73 iinn74 iinn75 iinn76 iinn77 iinn78 iinn79
+ iinn80 iinn81 iinn82 iinn83 iinn84 iinn85 iinn86 iinn87 iinn88 iinn89 iinn90 iinn91 iinn92 iinn93 iinn94 iinn95
+ iinn96 iinn97 iinn98 iinn99 iinn100 iinn101 iinn102 iinn103 iinn104 iinn105 iinn106 iinn107 iinn108 iinn109 iinn110 iinn111
+ iinn112 iinn113 iinn114 iinn115 iinn116 iinn117 iinn118 iinn119 iinn120 iinn121 iinn122 iinn123 iinn124 iinn125 iinn126 iinn127 Y
XTO iinn0 A Y TBUFIX1
XT1 iinn1 A Y TBUFIX1
XT2 iinn2 A Y TBUFIX1
XT3 iinn3 A Y TBUFIX1
XT4 iinn4 A Y TBUFIX1
XT5 iinn5 A Y TBUFIX1
XT6 iinn6 A Y TBUFIX1
XT7 iinn7 A Y TBUFIX1
XT8 iinn8 A Y TBUFIX1
XT9 iinn9 A Y TBUFIX1
XT10 iinn10 A Y TBUFIX1
XT11 iinn11 A Y TBUFIX1
XT12 iinn12 A Y TBUFIX1
XT13 iinn13 A Y TBUFIX1
XT14 iinn14 A Y TBUFIX1
XT15 iinn15 A Y TBUFIX1
XT16 iinn16 A Y TBUFIX1
XT17 iinn17 A Y TBUFIX1
XT18 iinn18 A Y TBUFIX1
XT19 iinn19 A Y TBUFIX1
XT20 iinn20 A Y TBUFIX1
XT123 iinn123 A Y TBUFIX1
XT124 iinn124 A Y TBUFIX1
XT125 iinn125 A Y TBUFIX1
XT126 iinn126 A Y TBUFIX1
XT127 iinn127 A Y TBUFIX1
ENDS

SUBCKT DCO OUTPUT INO IN1 IN2 IN3 IN4 IN5 IN6 IN7 IN8 IN9 IN10 IN11 IN12 IN13 IN14 IN15
+ IN16 IN17 IN18 IN19 IN20 IN21 IN22 IN23 IN24 IN25 IN26 IN27 IN28 IN29 IN30 IN31
+ IN32 IN33 IN34 IN35 IN36 IN37 IN38 IN39 IN40 IN41 IN42 IN43 IN44 IN45 IN46 IN47
+ IN48 IN49 IN50 IN51 IN52 IN53 IN54 IN55 IN56 IN57 IN58 IN59 IN60 IN61 IN62 IN63
+ IN64 IN65 IN66 IN67 IN68 IN69 IN70 IN71 IN72 IN73 IN74 IN75 IN76 IN77 IN78 IN79
+ IN80 IN81 IN82 IN83 IN84 IN85 IN86 IN87 IN88 IN89 IN90 IN91 IN92 IN93 IN94 IN95
+ IN96 IN97 IN98 IN99 IN100 IN101 IN102 IN103 IN104 IN105 IN106 IN107 IN108 IN109 IN110 IN111
+ IN112 IN113 IN114 IN115 IN116 IN117 IN118 IN119 IN120 IN121 IN122 IN123 IN124 IN125 IN126 IN127

XBO OUTPUT INO IN1 IN2 IN3 IN4 IN5 IN6 IN7 IN8 IN9 IN10 IN11 IN12 IN13 IN14 IN15
+ IN16 IN17 IN18 IN19 IN20 IN21 IN22 IN23 IN24 IN25 IN26 IN27 IN28 IN29 IN30 IN31
+ IN32 IN33 IN34 IN35 IN36 IN37 IN38 IN39 IN40 IN41 IN42 IN43 IN44 IN45 IN46 IN47
+ IN48 IN49 IN50 IN51 IN52 IN53 IN54 IN55 IN56 IN57 IN58 IN59 IN60 IN61 IN62 IN63
+ IN64 IN65 IN66 IN67 IN68 IN69 IN70 IN71 IN72 IN73 IN74 IN75 IN76 IN77 IN78 IN79
+ IN80 IN81 IN82 IN83 IN84 IN85 IN86 IN87 IN88 IN89 IN90 IN91 IN92 IN93 IN94 IN95
+ IN96 IN97 IN98 IN99 IN100 IN101 IN102 IN103 IN104 IN105 IN106 IN107 IN108 IN109 IN110 IN111
+ IN112 IN113 IN114 IN115 IN116 IN117 IN118 IN119 IN120 IN121 IN122 IN123 IN124 IN125 IN126 IN127 B BUFFER

XB1 B INO IN1 IN2 IN3 IN4 IN5 IN6 IN7 IN8 IN9 IN10 IN11 IN12 IN13 IN14 IN15
+ IN16 IN17 IN18 IN19 IN20 IN21 IN22 IN23 IN24 IN25 IN26 IN27 IN28 IN29 IN30 IN31
+ IN32 IN33 IN34 IN35 IN36 IN37 IN38 IN39 IN40 IN41 IN42 IN43 IN44 IN45 IN46 IN47
+ IN48 IN49 IN50 IN51 IN52 IN53 IN54 IN55 IN56 IN57 IN58 IN59 IN60 IN61 IN62 IN63
+ IN64 IN65 IN66 IN67 IN68 IN69 IN70 IN71 IN72 IN73 IN74 IN75 IN76 IN77 IN78 IN79
+ IN80 IN81 IN82 IN83 IN84 IN85 IN86 IN87 IN88 IN89 IN90 IN91 IN92 IN93 IN94 IN95
+ IN96 IN97 IN98 IN99 IN100 IN101 IN102 IN103 IN104 IN105 IN106 IN107 IN108 IN109 IN110 IN111
+ IN112 IN113 IN114 IN115 IN116 IN117 IN118 IN119 IN120 IN121 IN122 IN123 IN124 IN125 IN126 IN127 C BUFFER

XB2 C INO IN1 IN2 IN3 IN4 IN5 IN6 IN7 IN8 IN9 IN10 IN11 IN12 IN13 IN14 IN15
+ IN16 IN17 IN18 IN19 IN20 IN21 IN22 IN23 IN24 IN25 IN26 IN27 IN28 IN29 IN30 IN31
+ IN32 IN33 IN34 IN35 IN36 IN37 IN38 IN39 IN40 IN41 IN42 IN43 IN44 IN45 IN46 IN47
+ IN48 IN49 IN50 IN51 IN52 IN53 IN54 IN55 IN56 IN57 IN58 IN59 IN60 IN61 IN62 IN63
+ IN64 IN65 IN66 IN67 IN68 IN69 IN70 IN71 IN72 IN73 IN74 IN75 IN76 IN77 IN78 IN79
+ IN80 IN81 IN82 IN83 IN84 IN85 IN86 IN87 IN88 IN89 IN90 IN91 IN92 IN93 IN94 IN95
+ IN96 IN97 IN98 IN99 IN100 IN101 IN102 IN103 IN104 IN105 IN106 IN107 IN108 IN109 IN110 IN111
+ IN112 IN113 IN114 IN115 IN116 IN117 IN118 IN119 IN120 IN121 IN122 IN123 IN124 IN125 IN126 IN127 OUTPUT BUFFER

.ic v(OUTPUT)=0
. ENDS

CLUDE "ultrasim cells.sp"
