***Voltage: 1.8V ***
*. PARAM supply=1.8

*********************
* Define Global Nets*
*********************
*. GLOBAL VDD VSS

****************
Voltage Sources*
****************
*vdd VDD DC supply
*VSS VSS DC 0

**************
* TOP Circuit*
**************

.subckt PFD in fb reset b flagU flagD
XDFFO in VDD CDN QUN QU DFFRX4
XDFF1 fb VDD CDN QDN QD DFFRX4

XNANDO QU QD NANDO OUT NAND2X1
XANDO NANDO OUT RESET B CDN AND2X1

XBUFO QU BUFO OUT BUFX4
XBUF1 QD BUF1 OUT BUFX4

XINVO BUFO OUT INVO OUT INVX1
XINV1 BUF1 oUT INV1 OUT INVX1

XNAND10 QU INV1 OUT OUTU NAND2X1
XNAND11 QU INV1 OUT OUTU NAND2X1
XNAND20 QD INVO OUT OUTD NAND2X1
XNAND21 QD INVO OUT OUTD NAND2X1

XDPAO OUTU OUTBU DPA
XDPA1 OUTD OUTBD DPA

XDFF2 in VDD OUTBU flagUN flagU DFFRX4
XDFF3 fb VDD OUTBD flagDN flagD DFFRX4

.ic v(IN)=0
.ic v(FB)=0
.ic v(RESET_B)=0
**************************
* Digital Pulse Amplifier*
**************************
.subckt DPA INPUT OUTPUT
XSBUFO INPUT SBUFO OUT BUFX1
XSANDO INPUT SBUFO OUT SANDO OUT AND2X1
XSAND1 SANDO OUT SBUFO OUT SAND1 OUT AND2X1
XSAND2 SAND1 OUT SANDO OUT SAND2 OUT AND2X1
XSAND3 SAND2 OUT SAND1 OUT SAND3 OUT AND2X1
XSAND4 SAND3 OUT SAND2 OUT SAND4 OUT AND2X1
XSAND5 SAND4 OUT SAND3 OUT OUTPUT AND2X1
. ends

.INCLUDE "ultrasim_cells.sp"

END
